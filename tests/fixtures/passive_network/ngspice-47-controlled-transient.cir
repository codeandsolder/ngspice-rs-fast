Explicit physical controlled source witness
.options reltol=1e-8 abstol=1e-12 vntol=1e-10
v1 as 0 SIN(0 1 10k)
ra as a 2
ca a 0 1u
r1 a 0 3
v2 bs 0 SIN(0 1 10k)
rb bs bx 2
cb bs bx 1u
vp b bx 0
r2 b 0 3
f2 0 f vp 1
rf f 0 1
.tran 20n 2u 0 20n
.control
run
set numdgt=16
print v(a)[length(v(a))-1] v(b)[length(v(b))-1] v(f)[length(v(f))-1] i(vp)[length(i(vp))-1]
.endc
.end
