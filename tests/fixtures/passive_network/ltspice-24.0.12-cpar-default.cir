Synthetic minimum parallel capacitance
.options reltol=1e-10 abstol=1e-13 vntol=1e-12
V1 s 0 AC 1
R1 s p1 .1
C1 p1 0 2u Lser=3m
R2 s p2 .1
C2 p2 0 2u Lser=3m Cpar=0
R3 s p3 .1
C3 p3 0 2u Lser=3m Cpar=.1p
R4 s p4 .1
C4 p4 0 2u Lser=3m Cpar=3p
R5 s p5 .1
C5 p5 0 4u Lser=3m
R6 s p6 .1
C6 p6 0 2u Lser=0
R7 s p7 .1
C7 p7 0 2u Lser=3m m=3
.ac lin 1 1g 1g
.save V(p1) V(p2) V(p3) V(p4) V(p5) V(p6) V(p7)
.end
