* independent LTspice 24.0.12 prepared source witnesses
.param cycle_count=1.5
V1 a 0 DC 7 SINE(1 2 1Meg 1u 1e5 30 1.5)
V2 b 0 EXP(1 3 5u 2u 1u 3u)
I1 0 c PULSE(0 1 1u .1u .1u 8u 10u {cycle_count})
R1 c 0 1
V3 d 0 SINE(1 2 0 1u 1e5 30)
V4 e 0 SINE(1 2 -1Meg 1u 1e5 30 1.5)
V5 f 0 SINE(1 2 -1Meg 0 1e5 30 1.5)
V6 g 0 SINE(1 2 1Meg -2u 1e5 30 1.5)
V7 h 0 EXP(1 3 -2u 2u -1u 3u)
V8 i 0 SINE(1 -2 1Meg 1u -1e5 30 1.5)
.options reltol=1e-10 abstol=1e-14 vntol=1e-12 plotwinsize=0 method=gear numdgt=15
.save V(a) V(b) V(c) V(d) V(e) V(f) V(g) V(h) V(i)
.tran 0 20u 0 20n
.end
