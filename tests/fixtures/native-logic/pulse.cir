Native delay and feedback matrix
vin in 0 pwl(0 0 1u 0 1.1u 4 1.4u 4 1.5u 0 3u 0 3.1u 4 5u 4 5.1u 0 8u 0)
a1 %v[in] d1 m1
a2 %v[in] d2 m2
.model m1 preprocess_logic_event(delay=1u inertial=true low=2 high=3)
.model m2 preprocess_logic_event(delay=1u inertial=false low=2 high=3)
a3 d1 o1 bridge
a4 d2 o2 bridge
.model bridge preprocess_logic_voltage(out_low=0 out_high=5)
r1 o1 0 1k
r2 o2 0 1k
vset set 0 pwl(0 0 1u 0 1.1u 4 1.4u 4 1.5u 0 8u 0)
a5 %v[set cap] d5 latch
.model latch preprocess_logic_event(operation=4 delay=100n inertial=true low=2 high=3)
a6 d5 fb bridge
r3 fb cap 1k
c1 cap 0 1n
.end
