Switch transfer
.options reltol=1e-10 abstol=1e-14 vntol=1e-12
Vc c 0 0
V1 a 0 1
V2 b 0 1
V3 d 0 1
V4 e 0 1
S1 a 0 c 0 sm1
S2 b 0 c 0 sm2
S3 d 0 c 0 sm3
S4 e 0 c 0 sm4
.model sm1 SW(Ron=1 Roff=1Meg Vt=0 Vh=-1)
.model sm2 SW(Ron=1 Roff=1Meg Vt=0 Vh=1)
.model sm3 SW(Ron=1 Roff=1Meg Vt=0 Vh=0)
.model sm4 SW(Ron=1 Roff=1Meg Vt=0 Vh=-1 level=2)
.dc Vc -2 2 .25
.end
