Epsilon smoothing join
.options reltol=1e-10 abstol=1e-15 gmin=1e-12
Vc c 0 0
V1 a 0 -.1
V2 b 0 -.2
V3 d 0 -.21
V4 e 0 -.3
S1 a 0 c 0 m
S2 b 0 c 0 m
S3 d 0 c 0 m
S4 e 0 c 0 m
.model m SW(level=2 ron={1/g} roff={1/g} vh=-1 ilimit=.05 epsilon=.2)
.step param g list .01 .1 1 2 2.25 2.49 2.5 2.51 2.6 2.75 3 3.25 3.5 3.6078556 4 5 6 8 10 15 20 25 50 100 1000
.op
.end
