VDMOS P soft reverse recovery AC with Qp dynamic node
.options gmin=1e-20 reltol=1e-7 abstol=1e-14
Vgate g 0 0
Vdrive vin 0 dc 0.55 ac 1
Rdrive vin d 0.3
Cdrain d 0 300p
M1 d g 0 dut
.model dut vdmos(pchan vto=-3 kp=10 is=1e-12 n=1 cjo=1n m=0.5 fc=0.5 tt=100n vp=0.4)
.control
ac lin 1 1Meg 1Meg
print v(d)
quit
.endc
.end
