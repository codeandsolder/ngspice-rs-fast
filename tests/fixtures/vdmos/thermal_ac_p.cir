ngspice 47 VDMOS self-heating AC benchmark
.options gmin=1e-20 temp=27
Vg g 0 dc -4 ac 1
Vd d 0 -0.3
M1 d g 0 junction case dut thermal
.model dut vdmosp (vto=-3 kp=10 rthjc=1 rthca=5 cthj=10u mu=-1.5)
.control
ac lin 1 100 100
print v(junction) v(case) i(vd)
quit
.endc
.end
