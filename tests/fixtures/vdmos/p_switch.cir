P-channel VDMOS circuit-coupled nonlinear gate switching transient reference
.options reltol=1e-6 abstol=1e-12 method=trap
Vdd supply 0 -12
Rload supply drain 10
Cload drain 0 100n
Vgate gate 0 PWL(0 0 1u 0 1.05u -4 3u -4 3.05u 0 6u 0)
M1 drain gate 0 dut
.model dut VDMOS(PCHAN vto=-3 kp=10 is=1e-14 cgs=1.4n cgdmax=2n cgdmin=20p)
.control
tran 5n 6u 0 5n
meas tran pre find v(drain) at=0.5u
meas tran rising find v(drain) at=1.03u
meas tran on1 find v(drain) at=1.2u
meas tran on2 find v(drain) at=2.0u
meas tran falling find v(drain) at=3.03u
meas tran off1 find v(drain) at=3.3u
meas tran off2 find v(drain) at=5u
quit
.endc
.end
