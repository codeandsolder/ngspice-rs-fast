VDMOS N channel series resistance AC reference
Vdd supply 0 12
Rload supply drain 10
Vgate gate 0 dc 4 ac 1
M1 drain gate 0 dut
.model dut VDMOS(vto=3 kp=20 rd=0.12 rs=0.08 rg=0.9 rb=0.025 is=1e-14 rds=1200)
.control
ac lin 1 100k 100k
print v(drain)
quit
.endc
.end
