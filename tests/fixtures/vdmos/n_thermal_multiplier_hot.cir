Ngspice47 VDMOS N device electrothermal noise reference
.options temp=75 gmin=1e-20
vdd supply 0 DC 12 AC 1
vgate gate 0 4
rload supply drain 10
m1 drain gate 0 junction case dut thermal m=4
.model dut vdmos(vto=3 kp=20 rd=0.12 rs=0.08 rg=0.9 rb=0.025 is=1e-14 kf=1e-26 af=1.2 rthjc=3 rthca=12 cthj=10u mu=-1.5)
.control
op
print v(junction) v(case) @m1[id] @m1[temp]
noise v(drain) vdd dec 4 1k 1Meg 1
setplot noise1
print frequency onoise_spectrum inoise_spectrum
print onoise_m1_rd onoise_m1_rs onoise_m1_id onoise_m1_1overf onoise_m1
quit
.endc
.end
