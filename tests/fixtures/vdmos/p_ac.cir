VDMOS P channel circuit-coupled AC reference
Vdd supply 0 -12
Rload supply drain 10
Vgate gate 0 dc -4 ac 1
M1 drain gate 0 dut
.model dut VDMOS(PCHAN vto=-3 kp=10 is=1e-14 cgs=1.4n cgdmax=2n cgdmin=20p)
.control
ac lin 1 100k 100k
print v(drain)
quit
.endc
.end
