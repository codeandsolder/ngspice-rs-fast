VDMOS N series resistances nonlinear circuit reference
Vdd supply 0 12
Rload supply drain 10
Vgate gate 0 4
M1 drain gate 0 dut
.model dut VDMOS(vto=3 kp=20 rd=0.12 rs=0.08 rg=0.9 rb=0.025 is=1e-14 rds=1200)
.control
op
print v(drain) i(vdd) @m1[id] @m1[gm] @m1[gds]
quit
.endc
.end
