Ngspice 47 VDMOS gate and temperature candidate sweep
Vdd supply 0 12
Rload supply drain 10
Vgate gate 0 0
M1 drain gate 0 dut
.model dut vdmos(vto=3 kp=20 rd=0.12 rs=0.08 rg=0.9 rb=0.025 is=1e-14 rds=1200 mu=-1.5)
.control
dc Vgate 2 6 1 TEMP 0 100 50
print v(drain) i(vdd)
quit
.endc
.end
