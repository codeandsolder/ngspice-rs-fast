Independent charge and flux-dual ramp witness
.options reltol=1e-8 abstol=1e-12 vntol=1e-10 method=gear
Vc c 0 PWL(0 -1 1m 1)
Cq c 0 Q='1u*(v(c)+0.1*v(c)^2+0.1*v(c)^3)'
Vf f 0 PWL(0 -1 1m 1)
Cf f 0 Q='1m*(v(f)+0.1*v(f)^2+0.1*v(f)^3)'
.tran 1u 1m 0 1u
.control
run
set numdgt=16
set wr_singlescale
wrdata signed-ramp.tsv v(c) i(vc) v(f) i(vf)
.endc
.end
