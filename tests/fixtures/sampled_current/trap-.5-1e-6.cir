* occurrence-local sampled-current feedback witness
V1 drive 0 DC 2 PULSE(2 3 1u 100n 100n 2u 5u)
Bdrive s 0 V=V(drive)-.5*I(C1)
R1 s p 3
C1 p 0 2u Rser=5 Rpar=20 Cpar=1u
B1 b 0 V=I(C1)
R2 b 0 1
.options method=trap reltol=1e-6 abstol=1e-12 vntol=1e-9 plotwinsize=0 numdgt=15
.save V(drive) V(s) V(p) V(b) I(C1) I(R1)
.tran 0 5u 0 50n
.end
