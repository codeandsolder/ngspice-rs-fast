* Generic source current target selection
V1 drive 0 DC 2 AC 1
R1 drive p 3
R2 p 0 5
C1 drive 0 2u Rpar=0
R3 drive a 1
L1 a 0 3m Rser=0 Rpar=0
BV out 0 V=2*V(drive)
R4 out 0 3
BI 0 load I=V(drive)
R5 load 0 1
.func read(x) {I(x)}
.func nested(y) {read(y)}
BR r 0 V=nested(r2)
BC cap 0 V=read(c1)
BL ind 0 V=read(l1)
BVmon volt 0 V=read(bv)
BImon curr 0 V=read(bi)
BSmon src 0 V=read(v1)
E1 eout 0 drive 0 2
RE eout 0 3
BEmon emon 0 V=read(e1)
Vctrl ctrl 0 DC 2 AC 1
Rctrl ctrl 0 2
H1 hout 0 Vctrl 3
RH hout 0 3
BHmon hmon 0 V=read(h1)
G1 0 gout drive 0 2
RG gout 0 1
BGmon gmon 0 V=read(g1)
F1 0 fout Vctrl 2
RF fout 0 1
BFmon fmon 0 V=read(f1)
I1 0 iout DC 2 AC 1
RI iout 0 1
BImon2 imon 0 V=read(i1)
.options plotwinsize=0 numdgt=15
.save V(r) V(cap) V(ind) V(volt) V(curr) V(src) V(emon) V(hmon) V(gmon) V(fmon) V(imon) I(V1) I(R2) I(C1) I(L1) I(BV) I(BI) I(E1) I(H1) I(G1) I(F1) I(I1)
.ac lin 1 1k 1k
.end
