* selector boundaries
Vx x 0 DC 2 AC 1
V0 x a0 0
D0 a0 0 m0
.model m0 D(Level=-2 Ron=2 Roff=100 Vfwd=1)
V1 x a1 0
D1 a1 0 m1
.model m1 D(Level=-1.5 Ron=2 Roff=100 Vfwd=1)
V2 x a2 0
D2 a2 0 m2
.model m2 D(Level=-.5 Ron=2 Roff=100 Vfwd=1)
V3 x a3 0
D3 a3 0 m3
.model m3 D(Level=0 Ron=2 Roff=100 Vfwd=1)
V4 x a4 0
D4 a4 0 m4
.model m4 D(Level=.5 Ron=2 Roff=100 Vfwd=1)
V5 x a5 0
D5 a5 0 m5
.model m5 D(Level=1 Ron=2 Roff=100 Vfwd=1)
V6 x a6 0
D6 a6 0 m6
.model m6 D(Level=1.499999999 Ron=2 Roff=100 Vfwd=1)
V7 x a7 0
D7 a7 0 m7
.model m7 D(Level=1.5 Ron=2 Roff=100 Vfwd=1)
V8 x a8 0
D8 a8 0 m8
.model m8 D(Level=1.500000001 Ron=2 Roff=100 Vfwd=1)
V9 x a9 0
D9 a9 0 m9
.model m9 D(Level=2 Ron=2 Roff=100 Vfwd=1)
V10 x a10 0
D10 a10 0 m10
.model m10 D(Level=2.499999999 Ron=2 Roff=100 Vfwd=1)
V11 x a11 0
D11 a11 0 m11
.model m11 D(Level=2.5 Ron=2 Roff=100 Vfwd=1)
V12 x a12 0
D12 a12 0 m12
.model m12 D(Level=2.500000001 Ron=2 Roff=100 Vfwd=1)
V13 x a13 0
D13 a13 0 m13
.model m13 D(Level=3 Ron=2 Roff=100 Vfwd=1)
V14 x a14 0
D14 a14 0 m14
.model m14 D(Level=100 Ron=2 Roff=100 Vfwd=1)
.options gmin=1e-12 reltol=1e-10 abstol=1e-14 vntol=1e-12 plotwinsize=0 numdgt=15
.ac lin 3 1k 1meg
.end
