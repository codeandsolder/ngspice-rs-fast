* ordered and lexical LEVEL dispatch
Vx x 0 DC 2 AC 1
V0 x a0 0
V1 x a1 0
V2 x a2 0
V3 x a3 0
V4 x a4 0
V5 x a5 0
.param selector=2
.model dup0 D(LEVEL=1 LEVEL=2 Ron=2 Roff=100 Vfwd=1)
.model dup1 D(LEVEL=2 LEVEL=1 Ron=2 Roff=100 Vfwd=1)
.model expr D(LEVEL={selector} Ron=2 Roff=100 Vfwd=1)
D0 a0 0 dup0
D1 a1 0 dup1
D2 a2 0 expr
X3 a3 0 child sel=1
X4 a4 0 child sel=2
X5 a5 0 child sel=3
.subckt child a b sel=1
.model dm D(LEVEL={sel} Ron=2 Roff=100 Vfwd=1)
D1 a b dm
.ends child
.options gmin=1e-12 reltol=1e-10 abstol=1e-14 vntol=1e-12 plotwinsize=0 numdgt=15
.save I(V0) I(V1) I(V2) I(V3) I(V4) I(V5)
.ac lin 3 1k 1meg
.end
