Dense 32-mode cable
vin source 0 pulse(0 1 1n 0.6n 0.6n 8n 30n)
rs1 0 a1 50
rs2 0 a2 50
rs3 0 a3 50
rs4 0 a4 50
rs5 0 a5 50
rs6 0 a6 50
rs7 0 a7 50
rs8 0 a8 50
rs9 0 a9 50
rs10 0 a10 50
rs11 0 a11 50
rs12 0 a12 50
rs13 0 a13 50
rs14 0 a14 50
rs15 0 a15 50
rs16 0 a16 50
rs17 0 a17 50
rs18 0 a18 50
rs19 0 a19 50
rs20 0 a20 50
rs21 0 a21 50
rs22 0 a22 50
rs23 0 a23 50
rs24 0 a24 50
rs25 0 a25 50
rs26 0 a26 50
rs27 0 a27 50
rs28 0 a28 50
rs29 0 a29 50
rs30 0 a30 50
rs31 0 a31 50
rs32 source a32 50
rl1 b1 0 50
rl2 b2 0 50
rl3 b3 0 50
rl4 b4 0 50
rl5 b5 0 50
rl6 b6 0 50
rl7 b7 0 50
rl8 b8 0 50
rl9 b9 0 50
rl10 b10 0 50
rl11 b11 0 50
rl12 b12 0 50
rl13 b13 0 50
rl14 b14 0 50
rl15 b15 0 50
rl16 b16 0 50
rl17 b17 0 50
rl18 b18 0 50
rl19 b19 0 50
rl20 b20 0 50
rl21 b21 0 50
rl22 b22 0 50
rl23 b23 0 50
rl24 b24 0 50
rl25 b25 0 50
rl26 b26 0 50
rl27 b27 0 50
rl28 b28 0 50
rl29 b29 0 50
rl30 b30 0 50
rl31 b31 0 50
rl32 b32 0 50
p1 a1 a2 a3 a4 a5 a6 a7 a8 a9 a10 a11 a12 a13 a14 a15 a16 a17 a18 a19 a20 a21 a22 a23 a24 a25 a26 a27 a28 a29 a30 a31 a32 0 b1 b2 b3 b4 b5 b6 b7 b8 b9 b10 b11 b12 b13 b14 b15 b16 b17 b18 b19 b20 b21 b22 b23 b24 b25 b26 b27 b28 b29 b30 b31 b32 0 cable
.model cable cpl
+ r=20 0.1498606322700853 0.2374196160920432 0.1297515782805966 0.221233390052268 0.2104855258873892 0.1864671762311422 0.1874815776514119 0.2149808810736789 0.18909363055199 0.1384932938029572 0.1526612717566026 0.140574698398897 0.1627255901657652 0.2456859109939943 0.1664178541403687 0.1159147376305537 0.1734880567959501 0.2209974112884542 0.16907639248836 0.2053864449404373 0.1189219511704325 0.1148912987093978 0.1996509503493486 0.1128918168334505 0.1487763839582284 0.1604598948807626 0.1334329822762341 0.1112087666662316 0.1070189769203306 0.2406467023249428 0.2034630738626089 20.64516129032258 0.2406697849274521 0.175603798529473 0.2410406029900493 0.2280486138887438 0.193468620975793 0.180334916188448 0.1780027010039616 0.137951362349308 0.1592704744901066 0.2082998915513617 0.133677135006561 0.2262626092656703 0.1781674255291888 0.1915083630030578 0.2222912786244776 0.1974515593231888 0.1255429173590284 0.1411034193442571 0.1062154999315923 0.1099390650568793 0.2406256799791248 0.1899274074995062 0.2430726998365089 0.2164551059967513 0.1507286982969537 0.2428442146583887 0.2365358827995456 0.1705998685499642 0.1178410532144708 0.1510995923091091 21.29032258064516 0.1295842114651342 0.1577673563679117 0.1177361506977572 0.2069338880952152 0.2445962943060296 0.135872140033751 0.2163795839410875 0.1887151792181515 0.1743224249655084 0.2343780148796061 0.1594263562029949 0.222184072231562 0.1109816279407658 0.2425876472509438 0.1318899432618421 0.1065948748302833 0.2307038435848084 0.2080914025003211 0.2014983544785522 0.2143884979389587 0.1594330587399776 0.1222467838526103 0.1510654457295235 0.2409337551646703 0.2448651188911909 0.1385959322648558 0.1686056605488005 0.169791999106396 0.2339416945400075 21.93548387096774 0.1068476404561648 0.2233347308019824 0.141908563286323 0.1837258666975433 0.1243233685065403 0.1179562971851659 0.2309527866035749 0.1771906018177213 0.2435019133433687 0.2283743322031937 0.2124765254563092 0.1166222931405082 0.1894057826416116 0.2463897906991542 0.1772021538206257 0.1153851786080146 0.1321882966629975 0.2457834469463775 0.2442122429876424 0.1410028063961142 0.1511016247678349 0.2071782862308999 0.1778577138595145 0.1323011055064845 0.2452910231773512 0.1938476321670425 0.1577069343388274 0.1091751433689587 22.58064516129032 0.1782441116122047 0.2124124731031961 0.13121920063816 0.1184043950548954 0.2084705844629416 0.2362287492313293 0.1593717396556562 0.1729548591691738 0.1960694390606227 0.1796019164436982 0.1242182522638046 0.1449456237681928 0.1352119156992177 0.1339554617054386 0.1185382270785027 0.161389150388853 0.1370722628103573 0.2259281646249735 0.1516057717574034 0.2422807809802244 0.2207668824572493 0.1441416852195994 0.1278639413779681 0.1869741265730749 0.1731000995788958 0.1817269490137619 0.1234895707425537 23.2258064516129 0.1811824585439376 0.2134455922884789 0.1690193772593236 0.1421597300011795 0.236498642975121 0.1479368037847076 0.2468202243086642 0.2034675982322935 0.1063948402483959 0.1693435876923999 0.1271623272235576 0.2172730871609346 0.1656040159307243 0.1181627228423075 0.2407094257710205 0.2190991958824634 0.192009560681088 0.1863335624934158 0.1165719118267099 0.2450139530863179 0.1487378356394151 0.1801642344340771 0.1753648573874886 0.1728681741805799 0.1086378616683649 0.2323827108330011 23.87096774193548 0.1757157473570409 0.1617028730889566 0.2277828226509115 0.2277026110781467 0.2077466528171819 0.2344040721477223 0.1555041467012929 0.120884345344757 0.155250843988223 0.1911491912619803 0.2173466981636474 0.2099247386707915 0.1951151399352011 0.1910402583392575 0.2002609291537035 0.1873580752655973 0.108221647090779 0.1833716545815174 0.1450284861325556 0.1162880653919325 0.1926653437246747 0.2249860512813239 0.1460396091945979 0.2008265363341428 0.1945503680999792 24.51612903225806 0.2024299050591031 0.2293779329919974 0.2044496828378857 0.1173147313503597 0.1933360477401068 0.1553383393644065 0.1649923091665668 0.2015102642910979 0.130626056463431 0.1947442179129165 0.2387541585353889 0.1168795938766571 0.226481059094068 0.2061893299407397 0.1632256740599613 0.2143601378482252 0.1172898174743427 0.1288201806580248 0.2471481150523601 0.1940178085137244 0.1297699771108866 0.1243665933251547 0.1692583450552997 0.1833323577117112 25.16129032258064 0.2460457859625321 0.1323864809759693 0.1959650502818891 0.1683571264171763 0.1848649208885391 0.2392504704832191 0.1227971852467475 0.2241867792167291 0.2095184849782336 0.1439185120556671 0.1230384124342418 0.2116831914004128 0.2267396569960544 0.1549237571590347 0.125594115583817 0.1845647885067313 0.2009029159856028 0.156776129601094 0.164170542050568 0.1205447137434769 0.1260302717395168 0.1375156906783639 0.2132387605086976 25.80645161290322 0.1232768698577207 0.1340680359159885 0.1717250307029906 0.1357831166313406 0.1399692953650006 0.210262630952864 0.1391386654387815 0.1854820260445246 0.1180092833438891 0.179278157604299 0.2048044834579305 0.1693567160216393 0.1329326807466386 0.1103357015289075 0.1449666599477556 0.1638532585554697 0.1203287370065984 0.1663663404388054 0.1779629765264644 0.1151281401203961 0.200009297327297 0.2412294968519558 26.45161290322581 0.2054265396494198 0.1696461254263381 0.2238416794464292 0.239702124560926 0.2403834274807629 0.2406331143850468 0.2143493529891103 0.2394573863684746 0.2137944415885402 0.1520205441726306 0.1250827203559442 0.174945440490919 0.20547910673768 0.1441139759046111 0.1569736401199725 0.1176985782371412 0.1118551941634821 0.1426989851796471 0.2260625073066367 0.1146008230168064 0.1272586970922128 27.09677419354839 0.162565805527663 0.2429839962866969 0.1368530568269383 0.1122427224398674 0.1129783631684204 0.1547404042412738 0.1068514869889311 0.2009020381250813 0.114853897657113 0.1329217724984153 0.1168930326554033 0.1442689132116345 0.1185657552375353 0.1293025361172895 0.1334847283794416 0.1390611996358578 0.195794837387788 0.1583549157137248 0.1353805724130498 0.10777719923797 27.74193548387097 0.2284429688365739 0.2268057477974091 0.2401501626975406 0.2064116396608805 0.1672496649783527 0.1524626032370959 0.1336327363920131 0.1683292703452892 0.1652100497768453 0.2386783443157216 0.134384330370762 0.2049231201479748 0.2094096854416381 0.1991710856887856 0.1928133948391132 0.1120332713258992 0.1268388819141464 0.1793526536026358 0.1914088335934489 28.38709677419355 0.2421798975867366 0.217184011853199 0.1367188506934386 0.1270201408884587 0.2154721326810639 0.1075854667098694 0.2350317137743293 0.1183255039394114 0.1907755773946054 0.2256660208604326 0.1179602678499123 0.1204753286726562 0.1953984872127931 0.2078700762928298 0.1075227738638515 0.1723149062322454 0.2183394357860949 0.2157985774728521 29.03225806451613 0.1616813391928179 0.1072140892578249 0.1934307943261555 0.1819303818279327 0.1657376747515786 0.1903723353742127 0.1886903236548217 0.1741316770415811 0.1837543823671032 0.1854817025803321 0.2151979784294777 0.2179568367754076 0.1091400612506829 0.2169894416746762 0.140443740887613 0.1657435330788127 0.1368224101849757 29.67741935483871 0.1496676270587871 0.1623834759658769 0.1702629726895191 0.121087333458292 0.1476634976349229 0.1706564678358779 0.1606653954902083 0.1810202696601962 0.1158258870310422 0.185063311505507 0.2340778778086639 0.2105648390873385 0.1848834557962274 0.2200098972694968 0.1597846532833087 0.131072184009472 30.32258064516129 0.1926717453638886 0.1406223886113476 0.1447082244092379 0.2147968924241027 0.1780981745648224 0.1307620589976494 0.13675795226398 0.2098767586140417 0.1980142453554423 0.2331371764053607 0.2105654636112323 0.1463669809711785 0.2054131621516371 0.2307576485571889 0.2307687125103092 30.96774193548387 0.2352046044637759 0.126562890020222 0.1413811931229803 0.1305407403370965 0.221517689700157 0.2040925797964753 0.184978743726034 0.1338399207212266 0.1642568038526237 0.2037100974493465 0.1105941506586145 0.2320455006322876 0.2056406885000411 0.2325355474831125 31.61290322580645 0.2402286667008649 0.1789559918499212 0.1486300336756383 0.1597648551375723 0.1750414104749305 0.1916280080099091 0.1448041165201595 0.1468761812824416 0.1785550441567447 0.2106459920439413 0.1080425917724863 0.2335634482310834 0.1979492943772758 32.25806451612903 0.1769722983758437 0.1845115807211965 0.2223602186201904 0.1667505440257434 0.1520484906332745 0.118865135976902 0.1533366807808419 0.1146545675794961 0.142113688608777 0.1967649695665241 0.1566673027794969 0.2348592096320599 32.90322580645162 0.1724210462506186 0.22428966306168 0.1354172677768928 0.2443513627306279 0.2266042041591659 0.2340344547041327 0.2199851340890076 0.1794069834681692 0.1279260099904977 0.2253342870903696 0.2413429366204095 33.54838709677419 0.1707231783437936 0.2143339023387273 0.194474649038343 0.2149861659068222 0.2345539290005833 0.1980121368065533 0.1265155319421151 0.1680334888364817 0.1827461303225209 0.1379898309089975 34.19354838709678 0.2058685061089469 0.1523645180811685 0.1184560202948822 0.1567872180634062 0.210007198917748 0.1959505776308373 0.1518722865919653 0.1653486285629068 0.2035536825895501 34.83870967741935 0.2262885340754699 0.1212878895740764 0.1338995586903766 0.1645610104853073 0.136909335422925 0.1315805538196657 0.1488149008176711 0.126103247643349 35.48387096774194 0.111286072641028 0.1664343986510714 0.1678754706144386 0.1933299874643702 0.2377636174508589 0.2389987862299312 0.1734667828411267 36.12903225806451 0.1457554596219299 0.1934571248013391 0.1688111465937732 0.1896959265848105 0.2373112749963183 0.2134587432008431 36.7741935483871 0.2455824441402617 0.2208344089784319 0.2144120110549413 0.2467993958856793 0.2102108938061591 37.41935483870968 0.2118134263579318 0.2011408755945721 0.2430778615515149 0.1812624236787823 38.06451612903226 0.161338725362978 0.1928579875895705 0.1330597665426534 38.70967741935484 0.2173965790386656 0.1799535132018617 39.35483870967742 0.1566867004489089 40
+ l=2.50774217838533e-07 0 0 0 0 0 0 0 0 0 0 0 0 0 0 0 0 0 0 0 0 0 0 0 0 0 0 0 0 0 0 0 2.585877807978757e-07 0 0 0 0 0 0 0 0 0 0 0 0 0 0 0 0 0 0 0 0 0 0 0 0 0 0 0 0 0 0 2.659345091774795e-07 0 0 0 0 0 0 0 0 0 0 0 0 0 0 0 0 0 0 0 0 0 0 0 0 0 0 0 0 0 2.783569755390086e-07 0 0 0 0 0 0 0 0 0 0 0 0 0 0 0 0 0 0 0 0 0 0 0 0 0 0 0 0 2.807689765354173e-07 0 0 0 0 0 0 0 0 0 0 0 0 0 0 0 0 0 0 0 0 0 0 0 0 0 0 0 2.894604702250493e-07 0 0 0 0 0 0 0 0 0 0 0 0 0 0 0 0 0 0 0 0 0 0 0 0 0 0 2.897120310968601e-07 0 0 0 0 0 0 0 0 0 0 0 0 0 0 0 0 0 0 0 0 0 0 0 0 0 3.002505608942254e-07 0 0 0 0 0 0 0 0 0 0 0 0 0 0 0 0 0 0 0 0 0 0 0 0 3.100436325149405e-07 0 0 0 0 0 0 0 0 0 0 0 0 0 0 0 0 0 0 0 0 0 0 0 3.132925092366617e-07 0 0 0 0 0 0 0 0 0 0 0 0 0 0 0 0 0 0 0 0 0 0 3.239631365835005e-07 0 0 0 0 0 0 0 0 0 0 0 0 0 0 0 0 0 0 0 0 0 3.297857432705066e-07 0 0 0 0 0 0 0 0 0 0 0 0 0 0 0 0 0 0 0 0 3.311289615607973e-07 0 0 0 0 0 0 0 0 0 0 0 0 0 0 0 0 0 0 0 3.338784287192521e-07 0 0 0 0 0 0 0 0 0 0 0 0 0 0 0 0 0 0 3.478752525084144e-07 0 0 0 0 0 0 0 0 0 0 0 0 0 0 0 0 0 3.480382856156184e-07 0 0 0 0 0 0 0 0 0 0 0 0 0 0 0 0 3.533199148458087e-07 0 0 0 0 0 0 0 0 0 0 0 0 0 0 0 3.669842608752818e-07 0 0 0 0 0 0 0 0 0 0 0 0 0 0 3.745574518035783e-07 0 0 0 0 0 0 0 0 0 0 0 0 0 3.809464204549855e-07 0 0 0 0 0 0 0 0 0 0 0 0 3.885666171862178e-07 0 0 0 0 0 0 0 0 0 0 0 3.875005734443521e-07 0 0 0 0 0 0 0 0 0 0 3.927504915079761e-07 0 0 0 0 0 0 0 0 0 3.995945973984896e-07 0 0 0 0 0 0 0 0 4.146161664620749e-07 0 0 0 0 0 0 0 4.124095765682909e-07 0 0 0 0 0 0 4.193373597812378e-07 0 0 0 0 0 4.243945442966229e-07 0 0 0 0 4.311384838208462e-07 0 0 0 4.374794400777118e-07 0 0 4.470787109170959e-07 0 4.516326832374935e-07
+ g=0.001 -1.185577665994012e-05 -1.208939959718111e-05 -1.139645187324523e-05 -9.290686326120537e-06 -1.074203092695518e-05 -7.157369721784956e-06 -9.9586124875985e-06 -7.23664637786256e-06 -1.128060917206664e-05 -7.620171382848415e-06 -8.713084143737396e-06 -1.259042622240468e-05 -1.206738407460642e-05 -8.640720819276662e-06 -7.277660084814493e-06 -1.384035404587e-05 -1.011678005176524e-05 -7.480523393596367e-06 -1.078018666764388e-05 -1.285090654731434e-05 -1.127150750297271e-05 -9.116881012214287e-06 -1.070942697563259e-05 -9.664352602684212e-06 -1.37562575329968e-05 -1.270097842001376e-05 -8.542051973508009e-06 -1.139789993254609e-05 -1.277408869035433e-05 -8.510419573284803e-06 -8.074946945440378e-06 0.001032258064516129 -1.109661853040762e-05 -1.158771895959249e-05 -1.006539405548483e-05 -1.089488905377853e-05 -1.130186567156917e-05 -1.200183279293133e-05 -7.768967900970051e-06 -9.466798402053772e-06 -8.117284368119859e-06 -8.642550433135281e-06 -1.353134583226654e-05 -1.147061619136113e-05 -1.296377836385301e-05 -9.926746603347676e-06 -8.591919942334572e-06 -7.66991276010159e-06 -1.255100039794034e-05 -1.316123452228629e-05 -1.22440851549337e-05 -8.635831292141119e-06 -1.246915311096634e-05 -1.337133814670657e-05 -9.245023992230317e-06 -1.057506511309827e-05 -1.402910758252288e-05 -8.489425964511777e-06 -1.168444302355009e-05 -1.256313101333571e-05 -1.107785459022195e-05 -1.354683290602759e-05 0.001064516129032258 -1.060878388965477e-05 -8.21665661451815e-06 -9.626002509635019e-06 -9.295535683984706e-06 -1.066148756229256e-05 -9.724572821746276e-06 -1.294085161610952e-05 -1.149497525002879e-05 -1.272373203171169e-05 -1.131088821728363e-05 -7.575199672599162e-06 -8.33695344955308e-06 -7.954473309381931e-06 -1.213074763790162e-05 -9.627448214534946e-06 -1.289472424583044e-05 -1.337466569626469e-05 -1.309813171529447e-05 -1.173911837461e-05 -8.748217154433934e-06 -7.647999763319234e-06 -1.055310767403047e-05 -1.27131776680513e-05 -1.330134750764333e-05 -7.616827371006652e-06 -7.437375501923507e-06 -1.000708032335185e-05 -1.135633342008876e-05 -9.354176989890589e-06 0.001096774193548387 -1.195568194672693e-05 -1.243307269187274e-05 -1.294580151882146e-05 -1.363415454259341e-05 -8.291428155350713e-06 -1.373090712101549e-05 -7.556621083085716e-06 -1.13771177087905e-05 -1.255313226208817e-05 -7.887490495477863e-06 -8.952780358096933e-06 -1.191216573506563e-05 -1.008584237403206e-05 -7.84157427342584e-06 -7.426829367383066e-06 -1.136496947086414e-05 -8.045437944259191e-06 -8.141138748575192e-06 -8.931912099121203e-06 -1.085525305137337e-05 -7.642244685363489e-06 -9.409114155241787e-06 -9.080805703904013e-06 -8.856956928466359e-06 -1.236763247442047e-05 -1.035498983412494e-05 -1.262455855302091e-05 -1.365647666330036e-05 0.001129032258064516 -1.376328080684112e-05 -8.748514435788144e-06 -1.187730031894587e-05 -8.044855503419001e-06 -7.3238919379008e-06 -1.154101032494907e-05 -1.081613136766677e-05 -8.225698497575347e-06 -9.155174136306059e-06 -1.213598389282996e-05 -1.138705044977839e-05 -7.844600598904867e-06 -1.313953682496798e-05 -7.198671190545909e-06 -9.934200415306116e-06 -1.138975734516256e-05 -8.767072667932885e-06 -8.185038188706141e-06 -1.076317927633823e-05 -1.347976449093573e-05 -8.196312444536443e-06 -7.839443083167879e-06 -9.243537709635548e-06 -1.389357318377022e-05 -7.382911033233573e-06 -1.127808437411809e-05 -1.165268043616906e-05 0.001161290322580645 -1.37727434284084e-05 -8.017203044151443e-06 -1.23747066518938e-05 -1.009690335316269e-05 -1.339673064752964e-05 -1.366388366664069e-05 -1.142829161882054e-05 -1.15110678418717e-05 -7.887835770262084e-06 -9.266390961236462e-06 -1.349421487256388e-05 -1.160473266588268e-05 -8.896629462689103e-06 -8.433740438049973e-06 -1.284222104795698e-05 -1.266966460524199e-05 -1.162228022456985e-05 -1.283013763126301e-05 -8.535118449410035e-06 -1.051169317338939e-05 -1.321751389416611e-05 -1.218908934667579e-05 -9.804622819693944e-06 -9.815545402603536e-06 -1.318658608032212e-05 -1.192072237708279e-05 0.001193548387096774 -8.375861543842644e-06 -9.47094841487881e-06 -8.814454122498014e-06 -9.557367017168256e-06 -1.028468822595648e-05 -7.254209243678199e-06 -7.135851470096953e-06 -1.226053888336439e-05 -1.016485286129305e-05 -7.158937772242805e-06 -1.029842795785436e-05 -1.162624258234955e-05 -9.484068568735614e-06 -8.519772652873701e-06 -1.323874698041688e-05 -1.277552307506374e-05 -1.063399584041812e-05 -1.181296758941042e-05 -1.182093934567596e-05 -1.111324453117267e-05 -9.437626359694783e-06 -9.750654473038655e-06 -8.735344356490702e-06 -9.563995520464287e-06 -7.633723456220549e-06 0.001225806451612903 -1.270565903149051e-05 -9.183401937395725e-06 -7.228608378654327e-06 -8.518250856314042e-06 -1.282870010297778e-05 -1.123200934342103e-05 -8.482544834787644e-06 -7.445367340263359e-06 -9.884523929127431e-06 -1.100998680781194e-05 -1.134062417076563e-05 -7.976778734828083e-06 -1.250629828737403e-05 -1.298273546750984e-05 -1.089178122607384e-05 -1.392598293098188e-05 -8.723516394419627e-06 -8.776369107706705e-06 -8.512841841023003e-06 -1.335206040830037e-05 -1.314045912918672e-05 -8.576077550841507e-06 -1.220106307842888e-05 -9.501507914721466e-06 0.001258064516129032 -1.277343792216642e-05 -9.170653683125113e-06 -1.144165244539491e-05 -1.141088085010091e-05 -1.131604527741414e-05 -1.314220219960985e-05 -1.138715229886699e-05 -8.733997086905731e-06 -9.656016806879951e-06 -8.995373447184097e-06 -1.072487024044641e-05 -1.008727748486752e-05 -1.059008824440446e-05 -9.329708986209171e-06 -1.276011605923694e-05 -1.026582875327596e-05 -1.038722137372334e-05 -1.022704189275485e-05 -1.061474532405067e-05 -9.573363411895167e-06 -1.03969848390727e-05 -7.209227665035216e-06 -1.065134224526339e-05 0.001290322580645161 -8.61763074798998e-06 -9.840415460827049e-06 -7.847019294223726e-06 -7.649379862317168e-06 -9.644177047807168e-06 -1.146539391500667e-05 -7.085786387380339e-06 -1.355693963151928e-05 -8.486174412799607e-06 -9.283970355437695e-06 -8.865305187134494e-06 -1.376845204606746e-05 -1.315125140286719e-05 -1.389536277029614e-05 -1.234195011491072e-05 -1.255561130097027e-05 -7.795550017995964e-06 -9.043128092517838e-06 -1.342533847821227e-05 -1.020146948267312e-05 -8.185987659102613e-06 -9.865608891824057e-06 0.00132258064516129 -1.038162264252656e-05 -1.184128461292374e-05 -1.187315563979167e-05 -1.058270499056724e-05 -8.710802768529898e-06 -1.120685260266029e-05 -1.179605484251122e-05 -9.712008354391695e-06 -1.411442017368896e-05 -1.029580364812873e-05 -7.696833352400901e-06 -9.764889904132374e-06 -1.077841288646805e-05 -9.480189631891335e-06 -1.256938652231344e-05 -1.211196929230924e-05 -1.01674535214241e-05 -1.219398750531827e-05 -1.26720513847868e-05 -8.669737298454667e-06 -1.411908488673278e-05 0.001354838709677419 -7.108219856890323e-06 -1.382844619036325e-05 -1.242137126823838e-05 -1.281119684098803e-05 -7.082550276215972e-06 -1.300171260191789e-05 -8.635519844347213e-06 -8.918143105309627e-06 -1.333034651097576e-05 -1.051818824418232e-05 -1.38992723819446e-05 -1.195300647208434e-05 -1.331240020221054e-05 -1.143542327290389e-05 -1.38735357700743e-05 -1.158051720773947e-05 -9.748315120936714e-06 -9.132010296222345e-06 -1.097333110166932e-05 -8.800206621394301e-06 0.001387096774193548 -1.411207296087731e-05 -1.36827731702483e-05 -1.347035988965359e-05 -1.253222690348239e-05 -1.314312600995673e-05 -1.147277617309598e-05 -1.408788074158632e-05 -7.903580125418876e-06 -8.562294150081629e-06 -1.041744071520798e-05 -7.943133830817259e-06 -7.400264649970498e-06 -1.175563721223785e-05 -1.248817422660946e-05 -1.371558576536637e-05 -1.218744668945019e-05 -1.350942606771392e-05 -9.110222005232126e-06 -8.842056861429869e-06 0.001419354838709678 -1.042669434954747e-05 -7.103909974158453e-06 -7.655744567493269e-06 -9.394125772097198e-06 -1.127611467641464e-05 -1.336613484974847e-05 -1.033419150169349e-05 -1.128741265418509e-05 -8.393683453118495e-06 -1.362778968750562e-05 -1.221376856587921e-05 -9.946031058298378e-06 -7.173926714209316e-06 -1.23216029751742e-05 -9.786807234911271e-06 -1.253964328163454e-05 -8.607759608956143e-06 -1.326209165773985e-05 0.001451612903225807 -1.135849167070568e-05 -1.071051992007992e-05 -9.996611668192027e-06 -9.128761492606422e-06 -9.546590477323803e-06 -9.41866110959098e-06 -1.098484201839177e-05 -7.704488132637998e-06 -8.023307762152935e-06 -1.277108851644781e-05 -8.087221161454546e-06 -7.083523685556551e-06 -1.359998097612211e-05 -8.793993959131541e-06 -1.24485965086157e-05 -9.292427505235158e-06 -1.385329520371065e-05 0.001483870967741936 -7.940340373352664e-06 -8.870157128057993e-06 -1.17316136558103e-05 -8.269497233608766e-06 -9.561504221410596e-06 -9.992288761832735e-06 -1.283874409376324e-05 -1.167019537963598e-05 -1.043175406012986e-05 -8.920084991364677e-06 -7.584561249541035e-06 -1.400349608837551e-05 -9.564446924721503e-06 -7.907525845116102e-06 -1.006173593451218e-05 -7.943801393800868e-06 0.001516129032258064 -9.873018058484011e-06 -8.582053158582156e-06 -1.147855604646863e-05 -1.068162726207691e-05 -1.387919751412513e-05 -1.374147975453101e-05 -9.25945277062631e-06 -1.125340608420836e-05 -8.029895981586752e-06 -1.406177918833282e-05 -1.311104701807828e-05 -1.014419659946069e-05 -1.225664742498343e-05 -8.567536009970505e-06 -7.136510720286101e-06 0.001548387096774194 -7.236535012999499e-06 -9.313322216807457e-06 -1.06487246645793e-05 -8.845424624253178e-06 -8.717911088901771e-06 -1.20885490921826e-05 -8.684983565745246e-06 -9.176948058311244e-06 -9.462299242808423e-06 -7.272759876969443e-06 -1.370312911012326e-05 -1.166068569359118e-05 -7.43169907068633e-06 -7.332888088931332e-06 0.001580645161290323 -8.723127083818193e-06 -8.05549566641039e-06 -8.867219668855254e-06 -1.236430953010077e-05 -1.314339550418343e-05 -1.24673673871662e-05 -7.212497626110812e-06 -1.215122295918889e-05 -1.196030043232265e-05 -1.128863849595226e-05 -8.415258566936118e-06 -1.134412249050177e-05 -7.953121133898224e-06 0.001612903225806452 -1.075272846412882e-05 -1.283013551310708e-05 -1.231117631084704e-05 -1.298754167766263e-05 -1.358539216293766e-05 -9.200530225824499e-06 -8.689011335813489e-06 -9.543863483166832e-06 -1.205162477514413e-05 -8.919636771195237e-06 -7.930981364328121e-06 -1.150919286753309e-05 0.001645161290322581 -1.264030388190878e-05 -7.258812696311211e-06 -1.108456596378033e-05 -9.514830421090815e-06 -9.698536669660171e-06 -1.18920762365137e-05 -1.286056676916192e-05 -9.599310037033177e-06 -8.409569068277569e-06 -8.618677684969681e-06 -1.388876598475614e-05 0.00167741935483871 -8.217175450364985e-06 -1.094569431490049e-05 -9.712954160921263e-06 -1.26053264831218e-05 -9.917865250192365e-06 -1.252694390196839e-05 -1.403735315154829e-05 -7.907326749782708e-06 -1.110985006364627e-05 -1.34772809717762e-05 0.001709677419354839 -1.287389902538242e-05 -1.318841058803922e-05 -1.181856994097344e-05 -1.084899835907772e-05 -9.060051039265221e-06 -1.095422841040393e-05 -7.760960142361386e-06 -1.116227822514314e-05 -1.039960080640706e-05 0.001741935483870968 -1.35201363890409e-05 -1.371819870031437e-05 -1.018959105772982e-05 -9.742676398372621e-06 -1.320351124863651e-05 -1.0023473123712e-05 -1.12144799809333e-05 -8.411807563023117e-06 0.001774193548387097 -1.293375332461914e-05 -1.159653535522174e-05 -1.032353528385907e-05 -7.08146399128474e-06 -9.834066953599975e-06 -1.307820680856151e-05 -1.278703430452458e-05 0.001806451612903226 -1.398281988779853e-05 -9.033648702098374e-06 -1.039711366670386e-05 -8.492420033945814e-06 -1.232965200423945e-05 -9.933300133562088e-06 0.001838709677419355 -7.397161904174831e-06 -1.054885893450719e-05 -8.399549307643676e-06 -1.29117902612861e-05 -1.239442306600197e-05 0.001870967741935484 -7.389933584627909e-06 -1.088835141366651e-05 -1.093849785981268e-05 -1.009853405768858e-05 0.001903225806451613 -7.562589978980251e-06 -9.434013080467475e-06 -7.714630495520286e-06 0.001935483870967742 -1.402273612375355e-05 -7.958580301349883e-06 0.001967741935483871 -7.482360147718992e-06 0.002
+ c=1.003096871354132e-10 0 0 0 0 0 0 0 0 0 0 0 0 0 0 0 0 0 0 0 0 0 0 0 0 0 0 0 0 0 0 0 1.034351123191503e-10 0 0 0 0 0 0 0 0 0 0 0 0 0 0 0 0 0 0 0 0 0 0 0 0 0 0 0 0 0 0 1.063738036709918e-10 0 0 0 0 0 0 0 0 0 0 0 0 0 0 0 0 0 0 0 0 0 0 0 0 0 0 0 0 0 1.113427902156034e-10 0 0 0 0 0 0 0 0 0 0 0 0 0 0 0 0 0 0 0 0 0 0 0 0 0 0 0 0 1.123075906141669e-10 0 0 0 0 0 0 0 0 0 0 0 0 0 0 0 0 0 0 0 0 0 0 0 0 0 0 0 1.157841880900197e-10 0 0 0 0 0 0 0 0 0 0 0 0 0 0 0 0 0 0 0 0 0 0 0 0 0 0 1.15884812438744e-10 0 0 0 0 0 0 0 0 0 0 0 0 0 0 0 0 0 0 0 0 0 0 0 0 0 1.201002243576901e-10 0 0 0 0 0 0 0 0 0 0 0 0 0 0 0 0 0 0 0 0 0 0 0 0 1.240174530059762e-10 0 0 0 0 0 0 0 0 0 0 0 0 0 0 0 0 0 0 0 0 0 0 0 1.253170036946646e-10 0 0 0 0 0 0 0 0 0 0 0 0 0 0 0 0 0 0 0 0 0 0 1.295852546334002e-10 0 0 0 0 0 0 0 0 0 0 0 0 0 0 0 0 0 0 0 0 0 1.319142973082026e-10 0 0 0 0 0 0 0 0 0 0 0 0 0 0 0 0 0 0 0 0 1.324515846243189e-10 0 0 0 0 0 0 0 0 0 0 0 0 0 0 0 0 0 0 0 1.335513714877008e-10 0 0 0 0 0 0 0 0 0 0 0 0 0 0 0 0 0 0 1.391501010033658e-10 0 0 0 0 0 0 0 0 0 0 0 0 0 0 0 0 0 1.392153142462474e-10 0 0 0 0 0 0 0 0 0 0 0 0 0 0 0 0 1.413279659383235e-10 0 0 0 0 0 0 0 0 0 0 0 0 0 0 0 1.467937043501127e-10 0 0 0 0 0 0 0 0 0 0 0 0 0 0 1.498229807214313e-10 0 0 0 0 0 0 0 0 0 0 0 0 0 1.523785681819942e-10 0 0 0 0 0 0 0 0 0 0 0 0 1.554266468744871e-10 0 0 0 0 0 0 0 0 0 0 0 1.550002293777408e-10 0 0 0 0 0 0 0 0 0 0 1.571001966031905e-10 0 0 0 0 0 0 0 0 0 1.598378389593958e-10 0 0 0 0 0 0 0 0 1.658464665848299e-10 0 0 0 0 0 0 0 1.649638306273164e-10 0 0 0 0 0 0 1.677349439124951e-10 0 0 0 0 0 1.697578177186492e-10 0 0 0 0 1.724553935283385e-10 0 0 0 1.749917760310847e-10 0 0 1.788314843668384e-10 0 1.806530732949974e-10
+ length=1 sections=8
.tran 0.1n 12n 0 0.1n
.end
